** sch_path: /var/home/bleroux/Documents/stage_IEMN/analog-asic-design/designs/nmos.sch
**.subckt nmos
XM1 net3 net1 0 0 sg13_lv_nmos w=1.3u l=0.13u ng=1
VGS net1 0 3
VDS net2 0 3
VD net2 net3 0
.save i(vd)
**** begin user architecture code

.lib cornerMOSlv.lib mos_tt

.control

dc VDS 0 1.5 0.01 VGS 0 1.5 0.1
save all
plot i(VD)

.endc

**** end user architecture code
**.ends
.end
