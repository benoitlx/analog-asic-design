** sch_path: /var/home/bleroux/Documents/stage_IEMN/analog-asic-design/designs/nmos/nmos.sch
.subckt nmos
*.PININFO D:B G:B
XM1 D G GND GND sg13_lv_nmos w=0.15u l=0.13u ng=1
.ends nmos
.GLOBAL GND
