* Extracted by KLayout with SG13G2 LVS runset on : 18/06/2026 23:04

* cell TOP
.SUBCKT TOP
* device instance $1 r0 *1 2.345,0.41 sg13_lv_nmos
M$1 \$3 \$4 \$4 \$1 sg13_lv_nmos L=0.13u W=0.15u AS=0.1005p AD=0.1005p PS=1.34u
+ PD=1.34u
* device instance $2 r0 *1 4.425,0.41 sg13_lv_nmos
M$2 \$3 \$4 \$5 \$1 sg13_lv_nmos L=0.13u W=0.15u AS=0.1005p AD=0.1005p PS=1.34u
+ PD=1.34u
* device instance $3 r0 *1 6.715,0.41 sg13_lv_nmos
M$3 \$3 \$4 \$6 \$1 sg13_lv_nmos L=0.13u W=0.15u AS=0.1005p AD=0.1005p PS=1.34u
+ PD=1.34u
* device instance $4 r0 *1 3.415,1.005 sg13_lv_nmos
M$4 \$5 \$7 \$9 \$1 sg13_lv_nmos L=0.13u W=0.15u AS=0.1005p AD=0.1005p PS=1.34u
+ PD=1.34u
* device instance $5 r0 *1 5.32,1.01 sg13_lv_nmos
M$5 \$5 \$8 \$10 \$1 sg13_lv_nmos L=0.13u W=0.15u AS=0.1005p AD=0.1005p
+ PS=1.34u PD=1.34u
* device instance $6 r0 *1 6.7,1.85 sg13_lv_pmos
M$6 \$6 \$10 \$11 \$2 sg13_lv_pmos L=0.13u W=0.15u AS=0.1005p AD=0.1005p
+ PS=1.34u PD=1.34u
* device instance $7 r0 *1 3.395,2.38 sg13_lv_pmos
M$7 \$9 \$9 \$11 \$12 sg13_lv_pmos L=0.13u W=0.15u AS=0.1005p AD=0.1005p
+ PS=1.34u PD=1.34u
* device instance $8 r0 *1 5.325,2.38 sg13_lv_pmos
M$8 \$10 \$9 \$11 \$13 sg13_lv_pmos L=0.13u W=0.15u AS=0.1005p AD=0.1005p
+ PS=1.34u PD=1.34u
* device instance $9 r0 *1 7.755,1.845 ntap1
R$9 \$2 \$11 ntap1 A=0.6084p P=3.12u
* device instance $10 r0 *1 7.76,0.455 ptap1
R$10 \$1 \$3 ptap1 A=0.6084p P=3.12u
.ENDS TOP
