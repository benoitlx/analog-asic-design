** sch_path: /var/home/bleroux/Documents/stage_IEMN/analog-asic-design/designs/inverter/inverter.sch
.subckt TOP

M1 Vout net1 Vdd Vdd sg13_lv_pmos w=0.15u l=0.13u ng=1
M2 Vout net1 0 0 sg13_lv_nmos w=0.15u l=0.13u ng=1

.ends
