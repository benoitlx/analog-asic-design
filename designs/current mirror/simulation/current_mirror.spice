** sch_path: /var/home/bleroux/Documents/stage_IEMN/analog-asic-design/designs/current mirror/current_mirror.sch
**.subckt current_mirror
V2 Vdd 0 1.8
XM2 net2 net1 0 0 sg13_lv_nmos w=0.15u l=0.13u ng=1
XM1 net1 net1 0 0 sg13_lv_nmos w=0.15u l=0.13u ng=1
R1 Vdd net1 1k
R2 Vdd net2 1k
**** begin user architecture code

.lib cornerMOSlv.lib mos_tt

.control

op
print @R1[i]
print @R2[i]

alter R2=2k
op
print @R1[i]
print @R2[i]

alter R2=50k
op
print @R1[i]
print @R2[i]

.endc

**** end user architecture code
**.ends
.end
