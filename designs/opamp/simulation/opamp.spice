** sch_path: /var/home/bleroux/Documents/stage_IEMN/analog-asic-design/designs/opamp/opamp.sch
**.subckt opamp VDD Vref Vn Vp Vout Vss
*.ipin Vn
*.ipin Vp
*.opin Vout
*.iopin VDD
*.iopin Vref
*.iopin Vss
XM3 net2 Vn net1 net1 sg13_lv_nmos w=0.15u l=0.13u ng=1
XM4 net3 Vp net1 net1 sg13_lv_nmos w=0.15u l=0.13u ng=1
XM5 net2 net2 VDD VDD sg13_lv_pmos w=0.15u l=0.13u ng=1
XM6 net3 net2 VDD VDD sg13_lv_pmos w=0.15u l=0.13u ng=1
XM7 net1 Vref Vss Vss sg13_lv_nmos w=0.15u l=0.13u ng=1
XM8 Vout Vref Vss Vss sg13_lv_nmos w=0.15u l=0.13u ng=1
XM9 Vref Vref Vss Vss sg13_lv_nmos w=0.15u l=0.13u ng=1
XM10 Vout net3 VDD VDD sg13_lv_pmos w=0.15u l=0.13u ng=1
C1 Vout net3 10p
**** begin user architecture code

.lib cornerMOSlv.lib mos_tt

**** end user architecture code
**.ends
.end
