* Extracted by KLayout with SG13G2 LVS runset on : 15/04/2026 15:00

* cell nmos
.SUBCKT nmos
* device instance $1 r0 *1 0.435,0.15 sg13_lv_nmos
M$1 \$2 \$4 \$3 \$1 sg13_lv_nmos L=0.13u W=0.15u AS=0.1005p AD=0.1005p PS=1.34u
+ PD=1.34u
.ENDS nmos
